* Generated for: hspiceD
** Generated on: Nov  4 17:01:46 2025
** Design library name: cad3
** Design cell name: loaded_nand
** Design view name: schematic
.GLOBAL vss! vdd!

.TEMP 25
.OPTION
+    ARTIST=2
+    INGOLD=2
+    PARHIER=LOCAL
+    PSF=2
+    HIER_DELIM=0

** Library name: cad3
** Cell name: NAND2
** View name: schematic
*.subckt NAND2 a b out
*mpmos1 out b vdd! vdd! PMOS_VTL L=50e-9 W=250e-9 AD=26.25e-15 AS=26.25e-15 PD=460e-9 PS=460e-9 M=1
*mpmos0 out a vdd! vdd! PMOS_VTL L=50e-9 W=250e-9 AD=26.25e-15 AS=26.25e-15 PD=460e-9 PS=460e-9 M=1
*mnmos1 net1 b vss! vss! NMOS_VTL L=50e-9 W=300e-9 AD=31.5e-15 AS=31.5e-15 PD=510e-9 PS=510e-9 M=1
*mnmos0 out a net1 vss! NMOS_VTL L=50e-9 W=300e-9 AD=31.5e-15 AS=31.5e-15 PD=510e-9 PS=510e-9 M=1
*.ends NAND2
** End of subcircuit definition.

** ==== Post- layout netlist ====
.include loaded_nand.pex.netlist

** Library name: cad3
** Cell name: loaded_nand
** View name: schematic
xi4 vdd! z out4 NAND2
xi3 vdd! z out3 NAND2
xi2 vdd! z out2 NAND2
xi1 vdd! z out1 NAND2
xdut2 a b z NAND2
.END
