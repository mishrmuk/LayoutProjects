** Generated for: hspiceD
** Generated on: Dec  6 04:33:57 2025
** Design library name: cad5
** Design cell name: RF
** Design view name: schematic
.GLOBAL vdd! vss!

.TEMP 25
.OPTION
+    ARTIST=2
+    INGOLD=2
+    PARHIER=LOCAL
+    PSF=2
+    HIER_DELIM=0

.include RF.pex.netlist

*
xio CLK WR_EN WR_ADDR<1> WR_ADDR<0> WR_ADDR<2> WR_ADDR<3>
+ WR_DATA<15> RD_DATA_1<15> RD_DATA_0<15> RD_DATA_0<14> RD_DATA_1<14>
+ WR_DATA<14> WR_DATA<13> RD_DATA_1<13> RD_DATA_0<13> RD_DATA_1<12>
+ RD_DATA_0<12> WR_DATA<12> WR_DATA<11> RD_DATA_1<11> RD_DATA_0<11>
+ RD_DATA_0<10> RD_DATA_1<10> WR_DATA<10> WR_DATA<9> RD_DATA_1<9> RD_DATA_0<9>
+ RD_DATA_1<8> RD_DATA_0<8> WR_DATA<8> WR_DATA<7> RD_DATA_1<7> RD_DATA_0<7>
+ RD_DATA_0<6> RD_DATA_1<6> WR_DATA<6> WR_DATA<5> RD_DATA_1<5> RD_DATA_0<5>
+ RD_DATA_1<4> RD_DATA_0<4> WR_DATA<4> WR_DATA<3> RD_DATA_1<3> RD_DATA_0<3>
+ RD_DATA_0<2> RD_DATA_1<2> WR_DATA<2> WR_DATA<1> RD_DATA_1<1> RD_DATA_0<1>
+ RD_DATA_1<0> RD_DATA_0<0> WR_DATA<0> RD_ADDR_1<1> RD_ADDR_1<0> RD_ADDR_1<3>
+ RD_ADDR_1<2> RD_ADDR_0<1> RD_ADDR_0<0> RD_ADDR_0<3> RD_ADDR_0<2> RF
*
