** Generated for: hspiceD
** Generated on: Nov  5 21:01:31 2025
** Design library name: cad3
** Design cell name: ring_osc
** Design view name: schematic
.GLOBAL vss! vdd!

.TEMP 25
.OPTION
+    ARTIST=2
+    INGOLD=2
+    PARHIER=LOCAL
+    PSF=2
+    HIER_DELIM=0

** Library name: cad3
** Cell name: NAND2
** View name: schematic
*.subckt NAND2 a b out
*mpmos1 out b vdd! vdd! PMOS_VTL L=50e-9 W=250e-9 AD=26.25e-15 AS=26.25e-15 PD=460e-9 PS=460e-9 M=1
*mpmos0 out a vdd! vdd! PMOS_VTL L=50e-9 W=250e-9 AD=26.25e-15 AS=26.25e-15 PD=460e-9 PS=460e-9 M=1
*mnmos1 net1 b vss! vss! NMOS_VTL L=50e-9 W=300e-9 AD=31.5e-15 AS=31.5e-15 PD=510e-9 PS=510e-9 M=1
*mnmos0 out a net1 vss! NMOS_VTL L=50e-9 W=300e-9 AD=31.5e-15 AS=31.5e-15 PD=510e-9 PS=510e-9 M=1
*.ends NAND2
** End of subcircuit definition.

** Library name: cad3
** Cell name: INVD1
** View name: schematic
*.subckt INVD1 vi vo
*m0 vo vi vdd! vdd! PMOS_VTL L=50e-9 W=400e-9 AD=42e-15 AS=42e-15 PD=610e-9 PS=610e-9 M=1
*m1 vo vi vss! vss! NMOS_VTL L=50e-9 W=300e-9 AD=31.5e-15 AS=31.5e-15 PD=510e-9 PS=510e-9 M=1
*.ends INVD1
** End of subcircuit definition.

.include ring_osc.pex.netlist

** Library name: cad3
** Cell name: ring_osc
** View name: schematic
*xi0 osc_en osc_out net3 NAND2
*xi8 net17 osc_out INVD1
*xi7 net15 net17 INVD1
*xi6 net13 net15 INVD1
*xi5 net11 net13 INVD1
*xi4 net9 net11 INVD1
*xi3 net7 net9 INVD1
*xi2 net5 net7 INVD1
*xi1 net3 net5 INVD1

XRO1 osc_en osc_out ring_osc

.END
